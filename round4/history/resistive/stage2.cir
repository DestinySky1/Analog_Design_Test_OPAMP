.subckt block xp xm op om vdd 0
M5 op xp vdd vdd pch W=55.5u L=0.3u
M6 om xm vdd vdd pch W=55.5u L=0.3u
M7 op gp 0 0 nch W=28.2u L=0.5u
M8 om gm 0 0 nch W=28.2u L=0.5u
R3 op s 800k
R4 om s 800k
C3 op s 40f
C4 om s 40f
Rdp xp gp 1.5e+06
Rbp s gp 500000
Cdp xp gp 4.59348e-14
Rdm xm gm 1.5e+06
Rbm s gm 500000
Cdm xm gm 4.59348e-14
.ends block
