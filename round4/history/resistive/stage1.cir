.subckt block ip im xp xm vdd 0
Iref vdd b 2.077771516e-05
Mref b b 0 0 nch W=14.1u L=0.6u
Mtail t b 0 0 nch W=94.8u L=0.6u
M1 xp ip t 0 nch W=26.2u L=0.5u
M2 xm im t 0 nch W=26.2u L=0.5u
M3 xp a vdd vdd pch W=44.0u L=0.42u
M4 xm a vdd vdd pch W=44.0u L=0.42u
R1 xp a 800k
R2 xm a 800k
C1 xp a 40f
C2 xm a 40f
.ends block
