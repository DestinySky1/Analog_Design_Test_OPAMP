* Two-stage differential OTA, gm/ID stage design, 180 nm
.subckt ota ip im op om vdd 0
Iref vdd b 2.077771516e-05
Mref b b 0 0 nch W=14.1u L=0.6u
Mtail t b 0 0 nch W=94.8u L=0.6u
M1 xp ip t 0 nch W=26.2u L=0.5u
M2 xm im t 0 nch W=26.2u L=0.5u
M3 xp a vdd vdd pch W=44.0u L=0.42u
M4 xm a vdd vdd pch W=44.0u L=0.42u
R1 xp a 800k
R2 xm a 800k
C1 xp a 40f
C2 xm a 40f
M5 op xp vdd vdd pch W=52.3u L=0.3u
M6 om xm vdd vdd pch W=52.3u L=0.3u
M7 op s 0 0 nch W=11.7u L=0.42u
M8 om s 0 0 nch W=11.7u L=0.42u
M9 op xp 0 0 nch W=11.2u L=0.3u
M10 om xm 0 0 nch W=11.2u L=0.3u
R3 op s 800k
R4 om s 800k
C3 op s 40f
C4 om s 40f
Rzp xp zp 3910
Rzm xm zm 3910
Ccp zp op 200f
Ccm zm om 200f
.ends ota
